* plain_fail -- the same failing .save with no .control block
Vs In 0 DC 3
R1 In MidNode 1k
R2 MidNode 0 3k
.save v(midnode)
.op
.end
