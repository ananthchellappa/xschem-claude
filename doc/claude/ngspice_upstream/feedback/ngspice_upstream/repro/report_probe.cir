* report-only probe -- reads $casemode, never writes it; nets In / MidNode, source Vs
Vs In 0 DC 3
Rl In MidNode 1k
Rg MidNode 0 3k
.control
op
display
echo casemode-is $casemode
.endc
.end
