* partial .save under preserve: v(In) resolves, the folded net spelling does not
Vs In 0 DC 3
Rl In MidNode 1k
Rg MidNode 0 3k
.save v(In) v(midnode)
.control
op
display
write save_partial_lower.raw
.endc
.end
