* asymmetry table row: .print of the FOLDED spelling of net MidNode
Vs In 0 DC 3
Rl In MidNode 1k
Rg MidNode 0 3k
.dc Vs 1 3 1
.print dc v(midnode)
.control
run
.endc
.end
