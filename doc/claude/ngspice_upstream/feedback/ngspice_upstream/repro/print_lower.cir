* print with the FOLDED spelling of net MidNode -- works under preserve
Vs In 0 DC 3
Rl In MidNode 1k
Rg MidNode 0 3k
.control
op
print v(midnode)
.endc
.end
