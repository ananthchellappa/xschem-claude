* .save of a name no card defines -- silent in every mode, and on the baseline
Vs In 0 DC 3
Rl In MidNode 1k
Rg MidNode 0 3k
.save v(nosuchnode)
.control
op
write save_absent.raw
.endc
.end
