* finding 7: a deck with a .spiceinit beside it, to count the warning
Vs In 0 DC 3
Rl In 0 1k
.op
.end
